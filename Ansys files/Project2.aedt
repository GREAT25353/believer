# Ansys Electronics Desktop project, version 2023.2
materials:
  vacuum: permittivity=1
  M19_24G: permeability{HUnit=A_per_meter BUnit=tesla curve (0, 0) (22.28, 0.05) (25.46, 0.1) (31.83, 0.15) (47.74, 0.36) (63.66, 0.54) (79.57, 0.65) (159.15, 0.99) (318.3, 1.2) (477.46, 1.28) (636.61, 1.33) (795.77, 1.36) (1591.5, 1.44) (3183, 1.52) (4774.6, 1.58) (6366.1, 1.63) (7957.7, 1.67) (15915, 1.8) (31830, 1.9) (111407, 2) (190984, 2.1) (350138, 2.3) (509292, 2.5)} conductivity=1960000 core_loss_type="Electrical Steel" core_loss_kh=164.2 core_loss_kc=1.3 core_loss_ke=1.72 mass_density=7650
  XG196/96: permeability{HUnit=A_per_meter BUnit=tesla curve (-690000, 0) (-663114, 0.0487979) (-635338, 0.0975957) (-606628, 0.146394) (-576936, 0.195191) (-546211, 0.243989) (-514397, 0.292787) (-481437, 0.341585) (-447266, 0.390383) (-411817, 0.439181) (-375016, 0.487979) (-333348, 0.541105) (-291679, 0.593468) (-250011, 0.64583) (-208342, 0.698192) (-166674, 0.750554) (-125005, 0.802916) (-83337, 0.855278) (-41668.5, 0.907641) (0, 0.96)} magnetic_coercivity{Magnitude=-690000A_per_meter DirComp1=1 DirComp2=0 DirComp3=0}
  M19_24G_2DSF0.950: permeability{HUnit=A_per_meter BUnit=tesla curve (0, 0) (22.28, 0.0475014) (25.46, 0.0950016) (31.83, 0.142502) (47.74, 0.342003) (63.66, 0.513004) (79.57, 0.617505) (159.15, 0.94051) (318.3, 1.14002) (477.46, 1.21603) (636.61, 1.26354) (795.77, 1.29205) (1591.5, 1.3681) (3183, 1.4442) (4774.6, 1.5013) (6366.1, 1.5489) (7957.7, 1.587) (15915, 1.711) (31830, 1.807) (111407, 1.907) (190984, 2.007) (350138, 2.207) (509292, 2.407) (2100830, 4.407)} conductivity=1960000 core_loss_type="Electrical Steel" core_loss_kh=172.842 core_loss_kc=1.36842 core_loss_ke=1.76468 mass_density=7267.5
  XG196/96_2DSF1.000_N: CoordinateSystemType=Cylindrical permeability=1 magnetic_coercivity{Magnitude=-689995A_per_meter DirComp1=1 DirComp2=0 DirComp3=0}
  XG196/96_2DSF1.000_S: CoordinateSystemType=Cylindrical permeability=1 magnetic_coercivity{Magnitude=-689995A_per_meter DirComp1=-1 DirComp2=0 DirComp3=0}
  copper: permeability=0.999991 conductivity=58000000 mass_density=8933

design Maxwell2DDesign1 (Maxwell 2D, Transient, XY geometry, model units mm)
options: ComputeTransientInductance ModelDepth=65mm
variables:
  fractions = 4
geometry:
  Band [vacuum] = user_primitive(RMxprt/Band, DiaGap=74.5mm, DiaYoke=26mm, Length=0mm, SegAngle=0deg, Fractions=1, HalfAxial=0, InfoCore=0)
  Shaft [M19_24G_2DSF0.950] = user_primitive(RMxprt/Band, DiaGap=74.5mm, DiaYoke=26mm, Length=0mm, SegAngle=0deg, Fractions=1, HalfAxial=0, InfoCore=100)
  OuterRegion [vacuum] = user_primitive(RMxprt/Band, DiaGap=74.5mm, DiaYoke=120mm, Length=0mm, SegAngle=0deg, Fractions=fractions, HalfAxial=0, InfoCore=100)
  Tool = user_primitive(RMxprt/Band, DiaGap=74.5mm, DiaYoke=120mm, Length=0mm, SegAngle=0deg, Fractions=fractions, HalfAxial=0, InfoCore=1)
  Stator [M19_24G_2DSF0.950] = user_primitive(RMxprt/SlotCore, DiaGap=75mm, DiaYoke=120mm, Length=0mm, Skew=0deg, Slots=24, SlotType=2, Hs0=0.5mm, Hs01=0mm, Hs1=1mm, Hs2=8.2mm, Bs0=2.5mm, Bs1=5.6mm, Bs2=7.6mm, Rs=3.8mm, FilletType=0, HalfSlot=0, SegAngle=15deg, LenRegion=0mm, InfoCore=0)
  Coil_0 [copper] = user_primitive(RMxprt/LapCoil, DiaGap=75mm, DiaYoke=120mm, Length=0mm, Skew=0deg, Slots=24, SlotType=2, Hs0=0.5mm, Hs1=1mm, Hs2=8.2mm, Bs0=2.5mm, Bs1=5.6mm, Bs2=7.6mm, Rs=3.8mm, FilletType=0, Layers=2, CoilPitch=5, EndExt=0mm, SpanExt=0mm, BendAngle=0deg, SegAngle=10deg, LenRegion=0mm, InfoCoil=2)
  Coil_1..Coil_5 [copper], Coil_6..Coil_23 = Coil_0.duplicate_around_axis(axis=Z, angle=15deg, total=24)
  Coil_0.unite(Coil_6, Coil_12, Coil_18)
  Coil_1.unite(Coil_7, Coil_13, Coil_19)
  Coil_2.unite(Coil_8, Coil_14, Coil_20)
  Coil_3.unite(Coil_9, Coil_15, Coil_21)
  Coil_4.unite(Coil_10, Coil_16, Coil_22)
  Coil_5.unite(Coil_11, Coil_17, Coil_23)
  CoilRe_0 [copper] = user_primitive(RMxprt/LapCoil, DiaGap=75mm, DiaYoke=120mm, Length=0mm, Skew=0deg, Slots=24, SlotType=2, Hs0=0.5mm, Hs1=1mm, Hs2=8.2mm, Bs0=2.5mm, Bs1=5.6mm, Bs2=7.6mm, Rs=3.8mm, FilletType=0, Layers=2, CoilPitch=5, EndExt=0mm, SpanExt=0mm, BendAngle=0deg, SegAngle=10deg, LenRegion=0mm, InfoCoil=3)
  CoilRe_0.rotate(axis=Z, angle=-75deg)
  CoilRe_1..CoilRe_5 [copper], CoilRe_6..CoilRe_23 = CoilRe_0.duplicate_around_axis(axis=Z, angle=15deg, total=24)
  CoilRe_0.unite(CoilRe_6, CoilRe_12, CoilRe_18)
  CoilRe_1.unite(CoilRe_7, CoilRe_13, CoilRe_19)
  CoilRe_2.unite(CoilRe_8, CoilRe_14, CoilRe_20)
  CoilRe_3.unite(CoilRe_9, CoilRe_15, CoilRe_21)
  CoilRe_4.unite(CoilRe_10, CoilRe_16, CoilRe_22)
  CoilRe_5.unite(CoilRe_11, CoilRe_17, CoilRe_23)
  Rotor [M19_24G_2DSF0.950] = user_primitive(RMxprt/PMCore, DiaGap=74mm, DiaYoke=26mm, Length=0mm, Poles=4, PoleType=1, Embrace=0.7, ThickMag=3.53mm, WidthMag=0mm, Offset=0mm, Bridge=0mm, Rib=0mm, LenRegion=0mm, InfoCore=0)
  Mag_0 [XG196/96_2DSF1.000_N] = user_primitive(RMxprt/PMCore, DiaGap=74mm, DiaYoke=26mm, Length=0mm, Poles=4, PoleType=1, Embrace=0.7, ThickMag=3.53mm, WidthMag=0mm, Offset=0mm, Bridge=0mm, Rib=0mm, LenRegion=0mm, InfoCore=2)
  Mag_1, Mag_2, Mag_3 = Mag_0.duplicate_around_axis(axis=Z, angle=90deg, total=4)
  Mag_0.unite(Mag_1, Mag_2, Mag_3)
  InnerRegion [vacuum] = user_primitive(RMxprt/PMCore, DiaGap=74mm, DiaYoke=26mm, Length=0mm, Poles=4, PoleType=1, Embrace=0.7, ThickMag=3.53mm, WidthMag=0mm, Offset=0mm, Bridge=0mm, Rib=0mm, LenRegion=0mm, InfoCore=100)
  Tool_1 = Tool.copy()
  Band.subtract(Tool_1)
  Tool_2 = Tool.copy()
  InnerRegion.subtract(Tool_2)
  Tool_3 = Tool.copy()
  Shaft.subtract(Tool_3)
  Tool_4 = Tool.copy()
  Stator.subtract(Tool_4)
  Tool_5 = Tool.copy()
  Coil_0.subtract(Tool_5)
  Tool_6 = Tool.copy()
  Coil_1.subtract(Tool_6)
  Tool_7 = Tool.copy()
  Coil_2.subtract(Tool_7)
  Tool_8 = Tool.copy()
  Coil_3.subtract(Tool_8)
  Tool_9 = Tool.copy()
  Coil_4.subtract(Tool_9)
  Tool_10 = Tool.copy()
  Coil_5.subtract(Tool_10)
  Tool_11 = Tool.copy()
  CoilRe_0.subtract(Tool_11)
  Tool_12 = Tool.copy()
  CoilRe_1.subtract(Tool_12)
  Tool_13 = Tool.copy()
  CoilRe_2.subtract(Tool_13)
  Tool_14 = Tool.copy()
  CoilRe_3.subtract(Tool_14)
  Tool_15 = Tool.copy()
  CoilRe_4.subtract(Tool_15)
  Tool_16 = Tool.copy()
  CoilRe_5.subtract(Tool_16)
  Tool_17 = Tool.copy()
  Rotor.subtract(Tool_17)
  Mag_0.subtract(Tool)
motion:
  MotionSetup1: Band Move_Type=Rotate Coordinate_System=Global Axis=Z Is_Positive=true InitPos=7.5deg Angular_Velocity=1575.32rpm Objects=Band
  Moving1: Moving Objects=[Shaft, Rotor, Mag_0, InnerRegion]
boundaries and excitations:
  VectorPotential1: Vector Potential Edges=OuterRegion.edge(at (42.4264, 42.4264, 0)) Value=0
  Independent1: Independent Edges=OuterRegion.edge(at (30, 0, 0))
  Dependent1: Dependent Edges=OuterRegion.edge(at (0, 30, 0)) ReverseU Independent=Independent1 SameAsMaster=false
  PhA_0: Coil Objects=Coil_0 Conductor_number=25 Winding=PhaseA PolarityType=Positive
  PhARe_0: Coil Objects=CoilRe_5 Conductor_number=25 Winding=PhaseA PolarityType=Negative
  PhA_1: Coil Objects=Coil_1 Conductor_number=25 Winding=PhaseA PolarityType=Positive
  PhCRe_2: Coil Objects=Coil_2 Conductor_number=25 Winding=PhaseC PolarityType=Negative
  PhCRe_3: Coil Objects=Coil_3 Conductor_number=25 Winding=PhaseC PolarityType=Negative
  PhB_4: Coil Objects=Coil_4 Conductor_number=25 Winding=PhaseB PolarityType=Positive
  PhB_5: Coil Objects=Coil_5 Conductor_number=25 Winding=PhaseB PolarityType=Positive
  PhA_19: Coil Objects=CoilRe_0 Conductor_number=25 Winding=PhaseA PolarityType=Positive
  PhCRe_20: Coil Objects=CoilRe_1 Conductor_number=25 Winding=PhaseC PolarityType=Negative
  PhCRe_21: Coil Objects=CoilRe_2 Conductor_number=25 Winding=PhaseC PolarityType=Negative
  PhB_22: Coil Objects=CoilRe_3 Conductor_number=25 Winding=PhaseB PolarityType=Positive
  PhB_23: Coil Objects=CoilRe_4 Conductor_number=25 Winding=PhaseB PolarityType=Positive
  PhaseA: Winding Group Type=External IsSolid=false Current=0A ParallelBranchesNum=1
  PhaseB: Winding Group Type=External IsSolid=false Current=0A ParallelBranchesNum=1
  PhaseC: Winding Group Type=External IsSolid=false Current=0A ParallelBranchesNum=1
  external circuit: "* Design: MaxCir1"
mesh:
  SurfApprox_Mag: SurfApproxBased Objects=Mag_0 CurvedSurfaceApproxChoice=ManualSettings SurfDev=0.037mm NormalDev=15deg
  SurfApprox_Main: SurfApproxBased Objects=[Stator, Rotor, Band, OuterRegion, InnerRegion, Shaft] CurvedSurfaceApproxChoice=ManualSettings SurfDev=0.06mm NormalDev=15deg
  CylindricalGap1: CylindricalGap Objects=Band Objects=Band
setups:
  Setup1: Transient NonlinearSolverResidual=0.0001 StopTime=0.04s TimeStep=0.0002s OutputPerObjectCoreLoss InitialTimeStep=0.002s MinTimeStep=0.001s MaxTimeStep=0.003s TimeStepErrTolerance=0.0001
output variables:
  pos = (Moving1.Position -7.5 * PI/180) * 2 + PI
  cos0 = cos(pos)
  cos1 = cos(pos-2*PI/3)
  cos2 = cos(pos-4*PI/3)
  sin0 = sin(pos)
  sin1 = sin(pos-2*PI/3)
  sin2 = sin(pos-4*PI/3)
  Lad = L(PhaseA,PhaseA)*cos0 + L(PhaseA,PhaseB)*cos1 + L(PhaseA,PhaseC)*cos2
  Laq = L(PhaseA,PhaseA)*sin0 + L(PhaseA,PhaseB)*sin1 + L(PhaseA,PhaseC)*sin2
  Lbd = L(PhaseB,PhaseA)*cos0 + L(PhaseB,PhaseB)*cos1 + L(PhaseB,PhaseC)*cos2
  Lbq = L(PhaseB,PhaseA)*sin0 + L(PhaseB,PhaseB)*sin1 + L(PhaseB,PhaseC)*sin2
  Lcd = L(PhaseC,PhaseA)*cos0 + L(PhaseC,PhaseB)*cos1 + L(PhaseC,PhaseC)*cos2
  Lcq = L(PhaseC,PhaseA)*sin0 + L(PhaseC,PhaseB)*sin1 + L(PhaseC,PhaseC)*sin2
  L_d = (Lad*cos0 + Lbd*cos1 + Lcd*cos2) * 2/3
  L_q = (Laq*sin0 + Lbq*sin1 + Lcq*sin2) * 2/3
  Flux_d = (FluxLinkage(PhaseA)*cos0+FluxLinkage(PhaseB)*cos1+FluxLinkage(PhaseC)*cos2)*2/3
  Flux_q = (FluxLinkage(PhaseA)*sin0+FluxLinkage(PhaseB)*sin1+FluxLinkage(PhaseC)*sin2)*2/3
  I_d = (Current(PhaseA)*cos0 + Current(PhaseB)*cos1 + Current(PhaseC)*cos2)*2/3
  I_q = (Current(PhaseA)*sin0 + Current(PhaseB)*sin1 + Current(PhaseC)*sin2)*2/3
  Irms = sqrt(I_d^2+I_q^2)/sqrt(2)
  Pcu = 3*Irms^2*0
reports:
  Torque: Moving1.Torque vs Time on Setup1 : Transient
  Currents: Current(PhaseA), Current(PhaseB), Current(PhaseC) vs Time on Setup1 : Transient
  Induced Voltages: InducedVoltage(PhaseA), InducedVoltage(PhaseB), InducedVoltage(PhaseC) vs Time on Setup1 : Transient
  Flux Linkages: FluxLinkage(PhaseA), FluxLinkage(PhaseB), FluxLinkage(PhaseC) vs Time on Setup1 : Transient
  L_dq: L_d, L_q vs Time on Setup1 : Transient
  Flux_dq: Flux_d, Flux_q vs Time on Setup1 : Transient
  I_dq: I_d, I_q vs Time on Setup1 : Transient

design MaxCir1 (Maxwell Circuit)
variables:
  Kle = 1
components:
  Winding_14 = Winding(Name=PhaseA)
  Winding_21 = Winding(Name=PhaseB)
  Winding_28 = Winding(Name=PhaseC)
  Res_35 = Res(Name=A R=1.44235ohm)
  Res_42 = Res(Name=B R=1.44235ohm)
  Res_49 = Res(Name=C R=1.44235ohm)
  Ind_56 = Ind(Name=A L=0.000597162H*Kle)
  Ind_63 = Ind(Name=B L=0.000597162H*Kle)
  Ind_70 = Ind(Name=C L=0.000597162H*Kle)
  Ammeter_77 = Ammeter(Name=IA)
  Ammeter_84 = Ammeter(Name=IB)
  Ammeter_91 = Ammeter(Name=IC)
  VPulse_98 = VPulse(V1=-1 Td=15 Tr=0 Tf=0 Pw=60 Period=180 Type=POS)
  VPulse_105 = VPulse(V1=-1 Td=45 Tr=0 Tf=0 Pw=60 Period=180 Type=POS)
  VPulse_112 = VPulse(V1=-1 Td=75 Tr=0 Tf=0 Pw=60 Period=180 Type=POS)
  VPulse_119 = VPulse(V1=-1 Td=105 Tr=0 Tf=0 Pw=60 Period=180 Type=POS)
  VPulse_126 = VPulse(V1=-1 Td=135 Tr=0 Tf=0 Pw=60 Period=180 Type=POS)
  VPulse_133 = VPulse(V1=-1 Td=165 Tr=0 Tf=0 Pw=60 Period=180 Type=POS)
  Res_140 = Res()
  Res_147 = Res()
  Res_154 = Res()
  Res_161 = Res()
  Res_168 = Res()
  Res_175 = Res()
  VoltmeterG_182 = VoltmeterG(Name=Vc1)
  VoltmeterG_189 = VoltmeterG(Name=Vc2)
  VoltmeterG_196 = VoltmeterG(Name=Vc3)
  VoltmeterG_203 = VoltmeterG(Name=Vc4)
  VoltmeterG_210 = VoltmeterG(Name=Vc5)
  VoltmeterG_217 = VoltmeterG(Name=Vc6)
  VDC_224 = VDC(V=110V)
  VDC_231 = VDC(V=110V)
  DIODE_238 = DIODE(MOD=DModel1)
  DIODE_245 = DIODE(MOD=DModel1)
  DIODE_252 = DIODE(MOD=DModel1)
  DIODE_259 = DIODE(MOD=DModel1)
  DIODE_266 = DIODE(MOD=DModel1)
  DIODE_273 = DIODE(MOD=DModel1)
  DIODE_280 = DIODE(MOD=DModel1)
  DIODE_287 = DIODE(MOD=DModel1)
  DIODE_294 = DIODE(MOD=DModel1)
  DIODE_301 = DIODE(MOD=DModel1)
  DIODE_308 = DIODE(MOD=DModel1)
  DIODE_315 = DIODE(MOD=DModel1)
  SW_V_322 = SW_V(ID_V=IVc1 MOD=SModel1)
  SW_V_329 = SW_V(ID_V=IVc4 MOD=SModel1)
  SW_V_336 = SW_V(ID_V=IVc3 MOD=SModel1)
  SW_V_343 = SW_V(ID_V=IVc6 MOD=SModel1)
  SW_V_350 = SW_V(ID_V=IVc5 MOD=SModel1)
  SW_V_357 = SW_V(ID_V=IVc2 MOD=SModel1)
  DIODE_Model_364 = DIODE_Model(RS=0.413264ohm DeviceName=DModel1)
  SW_VModel_371 = SW_VModel(Von=0V Voff=0V DeviceName=SModel1)
nets:
  0: VDC_224.1, VDC_231.0, VPulse_119.1, VPulse_133.1, VPulse_105.1, VPulse_112.1, VPulse_98.1, VPulse_126.1
  net_1: Winding_14.1, Winding_21.1, Winding_28.1
  net_10: Ind_56.0, Ammeter_77.1
  net_11: Ind_63.0, Ammeter_84.1
  net_12: Ammeter_91.1, Ind_70.0
  net_19: Res_140.0, VoltmeterG_182.0, VPulse_98.0
  net_20: VPulse_105.0, VoltmeterG_189.0, Res_147.0
  net_21: Res_154.0, VPulse_112.0, VoltmeterG_196.0
  net_22: VoltmeterG_203.0, VPulse_119.0, Res_161.0
  net_23: VoltmeterG_210.0, Res_168.0, VPulse_126.0
  net_24: VoltmeterG_217.0, VPulse_133.0, Res_175.0
  net_25: Res_140.1, Res_154.1, Res_161.1, Res_168.1, Res_175.1, Res_147.1
  net_31: VDC_224.0, DIODE_280.0, DIODE_294.0, DIODE_259.1, DIODE_273.1, DIODE_308.0, DIODE_245.1
  net_33: SW_V_357.1, SW_V_329.1, DIODE_252.0, DIODE_238.0, SW_V_343.1, VDC_231.1, DIODE_266.0
  net_34: DIODE_287.0, SW_V_322.1, DIODE_238.1, DIODE_245.0, Ammeter_77.0
  net_35: DIODE_301.0, DIODE_252.1, SW_V_336.1, DIODE_259.0, Ammeter_84.0
  net_36: DIODE_315.0, DIODE_273.0, DIODE_266.1, SW_V_350.1, Ammeter_91.0
  net_4: Winding_14.0, Res_35.1
  net_40: SW_V_322.0, DIODE_280.1
  net_41: DIODE_287.1, SW_V_329.0
  net_42: SW_V_336.0, DIODE_294.1
  net_43: DIODE_301.1, SW_V_343.0
  net_44: DIODE_308.1, SW_V_350.0
  net_45: SW_V_357.0, DIODE_315.1
  net_5: Winding_21.0, Res_42.1
  net_6: Winding_28.0, Res_49.1
  net_7: Res_35.0, Ind_56.1
  net_8: Ind_63.1, Res_42.0
  net_9: Res_49.0, Ind_70.1

design RMxprtDesign1 (RMxprt, Brushless Permanent-Magnet DC Motor, model units mm)
variables:
  len = 65mm
machine:
  Machine: FrictionLoss=0W WindLoss=0W ReferenceSpeed=1500rpm NumberOfPoles=4 RotorPosition=true ControlType=0 CircuitType=Y3
  Circuit: TriggerPulseWidth=120deg TransistorDrop=2V DiodeDrop=2V LeadAngleOfTrigger=0deg MaximumCurrent=0A MinimumCurrent=0A
  Stator: SkewWidth=0 NumberOfSlots=24 LaminationSectors=0 PressBoardThickness=0mm OuterDiameter=120mm InnerDiameter=75mm Length=len StackingFactor=0.95 SteelType=M19_24G SlotType=2
  Rotor: OuterDiameter=74mm InnerDiameter=26mm Length=65mm SteelType=M19_24G PoleType=1 StackingFactor=0.95
  Shaft: MagneticShaft
  Stator Slot: Hs0=0.5mm Hs1=1mm Hs2=8.2mm Bs0=2.5mm Bs1=5.6mm Bs2=7.6mm Rs=0mm ToothWidth=0mm
  Stator Winding: WindingType=Whole-Coiled WindingLayers=2 ParallelBranches=1 ConductorsPerSlot=50 CoilPitch=5 EndAdjustment=0mm BaseInnerRadius=0mm TipInnerDiameter=0mm EndClearance=0mm CoilWrap=0mm SlotLiner=0mm WedgeThickness=0mm LayerInsulation=0mm BottomInsulation=0mm LimitedFillFactor=0.75 WdgNumberofPriodicMultipler=1 NumberOfStrands=1 WireWrap=0mm InterturnInsulation=0mm WireDiameter=0mm WireWidth=0mm WireThickness=0mm Gauge=AUTO
  Rotor Pole: Embrace=0.7 Offset=0mm ShaftDiameter=0mm Bridge=0mm Rib=0mm MagnetThickness=3.53mm MagnetWidth=0mm MagnetType=XG196/96
setups:
  Setup1: BLDC Motor RatedOutputPower=550W RatedVoltage=220V RatedSpeed=1500rpm OperatingTemperature=75cel LoadType=ConstPower
optimetrics:
  ParametricSetup1: Parametric Sim._Setups=[Setup1]
    sweep len: LIN 30mm 50mm 1mm
reports:
  Current Plot 1: SourceCurrent vs ElectricalDegree on Setup1 : Performance
  Torque Plot 1: OutputTorque, OutputPower, Efficiency vs RSpeed on Setup1 : Performance
  Torque Plot 2: OutputTorque vs RSpeed on Setup1 : Performance [len=all]
